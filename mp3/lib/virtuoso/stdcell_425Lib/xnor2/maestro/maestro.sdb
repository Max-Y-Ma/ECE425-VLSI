ADE simulation setup
Run mode: Single Run, Sweeps and Corners
Tests:
  stdcell_425Lib_xnor2_1: stdcell_425Lib/xnor2/schematic, simulator spectre
