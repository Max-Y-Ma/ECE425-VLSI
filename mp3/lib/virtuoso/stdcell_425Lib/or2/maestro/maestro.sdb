ADE simulation setup
Run mode: Single Run, Sweeps and Corners
Tests:
  stdcell_425Lib_or2_1: stdcell_425Lib/or2/schematic, simulator spectre
