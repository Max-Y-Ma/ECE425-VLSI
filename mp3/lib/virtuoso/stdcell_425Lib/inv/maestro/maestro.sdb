ADE simulation setup
Run mode: Single Run, Sweeps and Corners
Tests:
  stdcell_425Lib_inv_1: stdcell_425Lib/inv/schematic, simulator spectre
