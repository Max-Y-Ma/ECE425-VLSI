ADE simulation setup
Run mode: Single Run, Sweeps and Corners
Tests:
  stdcell_425Lib_nand2_1: stdcell_425Lib/nand2/schematic, simulator spectre
