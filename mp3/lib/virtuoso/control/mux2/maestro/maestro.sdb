ADE simulation setup
Run mode: Single Run, Sweeps and Corners
Tests:
  stdcell_425Lib_mux2_1: stdcell_425Lib/mux2/schematic, simulator spectre
