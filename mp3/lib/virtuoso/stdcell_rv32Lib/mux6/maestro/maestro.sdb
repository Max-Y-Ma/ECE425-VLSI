ADE simulation setup
Run mode: Single Run, Sweeps and Corners
Tests:
  stdcell_rv32Lib_mux6_1: stdcell_rv32Lib/mux6/schematic, simulator spectre
