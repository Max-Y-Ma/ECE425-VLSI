ADE simulation setup
Run mode: Single Run, Sweeps and Corners
Tests:
  stdcell_rv32Lib_mux5_1: stdcell_rv32Lib/mux5/schematic, simulator spectre
