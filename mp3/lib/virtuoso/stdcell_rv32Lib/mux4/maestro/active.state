ADE simulation setup
Test stdcell_rv32Lib_mux4_1: stdcell_rv32Lib/mux4/schematic, simulator spectre
  Models: /class/ece425/FreePDK45/ncsu_basekit/models/hspice/hspice_nom.include
  Temperature: 27
  Stimulus vdd!: voltage dc dc=1
  Stimulus vss!: voltage dc dc=0
  Stimulus S1: voltage bit val1=1 val0=0 delay=0 rise=10p fall=10p period=2.5n data=0011
  Stimulus S0: voltage bit val1=1 val0=0 delay=0 rise=10p fall=10p period=2.5n data=0101
  Stimulus A: voltage bit val1=1 val0=0 delay=0 rise=10p fall=10p period=2.5n data=0000
  Stimulus B: voltage bit val1=1 val0=0 delay=0 rise=10p fall=10p period=2.5n data=1111
  Stimulus C: voltage bit val1=1 val0=0 delay=0 rise=10p fall=10p period=2.5n data=0000
  Stimulus D: voltage bit val1=1 val0=0 delay=0 rise=10p fall=10p period=2.5n data=1111
  Analysis tran: stop=10n
  Signals: /A, /B, /C, /D, /Z, /S0, /S1
