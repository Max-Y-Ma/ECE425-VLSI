ADE simulation setup
Run mode: Single Run, Sweeps and Corners
Tests:
  stdcell_rv32Lib_muxinv2_1: stdcell_rv32Lib/muxinv2/schematic, simulator spectre
