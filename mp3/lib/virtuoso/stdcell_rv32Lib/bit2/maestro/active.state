ADE simulation setup
Test stdcell_rv32Lib_bit2_1: stdcell_rv32Lib/bit2/schematic, simulator spectre
  Models: /class/ece425/FreePDK45/ncsu_basekit/models/hspice/hspice_nom.include
  Temperature: 27
  Stimulus vdd!: voltage dc dc=1
  Stimulus vss!: voltage dc dc=0
  Stimulus A: voltage bit val1=1 val0=0 delay=0 rise=10p fall=10p period=2.5n data=0011
  Stimulus W: voltage bit val1=1 val0=0 delay=0 rise=10p fall=10p period=2.5n data=1010
  Stimulus R1: voltage bit val1=1 val0=0 delay=0 rise=10p fall=10p period=2.5n data=0111
  Stimulus R2: voltage bit val1=1 val0=0 delay=0 rise=10p fall=10p period=2.5n data=0111
  Analysis tran: stop=10n
  Signals: /R1, /R2, /W, /Z1, /Z2, /A
Run mode: Single Run, Sweeps and Corners
