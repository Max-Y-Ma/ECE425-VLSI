ADE simulation setup
Run mode: Single Run, Sweeps and Corners
Tests:
  stdcell_425Lib_nor2_1: stdcell_425Lib/nor2/schematic, simulator spectre
