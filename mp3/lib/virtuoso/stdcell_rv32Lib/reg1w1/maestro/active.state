ADE simulation setup
Test stdcell_rv32Lib_reg1w1_1: stdcell_rv32Lib/reg1w1/schematic, simulator spectre
  Models: /class/ece425/FreePDK45/ncsu_basekit/models/hspice/hspice_nom.include
  Temperature: 27
  Stimulus RE: voltage bit val1=1 val0=0 delay=0 rise=10p fall=10p period=2.5n data=01000101
  Stimulus CLK: voltage bit val1=1 val0=0 delay=0 rise=10p fall=10p period=2.5n data=01010101
  Stimulus D: voltage bit val1=1 val0=0 delay=0 rise=10p fall=10p period=2.5n data=10000111
  Stimulus WE: voltage bit val1=1 val0=0 delay=0 rise=10p fall=10p period=2.5n data=10001010
  Stimulus vdd!: voltage dc dc=1
  Stimulus vss!: voltage dc dc=0
  Analysis tran: stop=20n
  Signals: /RE, /WE, /CLK, /Q, /D, /Qb
