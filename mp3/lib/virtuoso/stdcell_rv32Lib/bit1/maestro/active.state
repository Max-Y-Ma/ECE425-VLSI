ADE simulation setup
Test stdcell_rv32Lib_bit1_1: stdcell_rv32Lib/bit1/schematic, simulator spectre
  Models: /class/ece425/FreePDK45/ncsu_basekit/models/hspice/hspice_nom.include
  Temperature: 27
  Stimulus W: voltage bit val1=1 val0=0 delay=0 rise=10p fall=10p period=2.5n data=1010
  Stimulus R: voltage bit val1=1 val0=0 delay=0 rise=10p fall=10p period=2.5n data=1111
  Stimulus A: voltage bit val1=1 val0=0 delay=0 rise=10p fall=10p period=2.5n data=1001
  Stimulus vss!: voltage dc dc=0
  Stimulus vdd!: voltage dc dc=1
  Analysis tran: stop=10n
  Signals: /A, /Z, /W, /R
