ADE simulation setup
Test stdcell_rv32Lib_fa_1: stdcell_rv32Lib/fa/schematic, simulator spectre
  Models: /class/ece425/FreePDK45/ncsu_basekit/models/hspice/hspice_nom.include
  Temperature: 27
  Stimulus vss!: voltage dc dc=0
  Stimulus vdd!: voltage dc dc=1
  Stimulus Cin: voltage bit val1=1 val0=0 delay=0 rise=10p fall=10p period=2.5n data=01010101
  Stimulus A: voltage bit val1=1 val0=0 delay=0 rise=10p fall=10p period=2.5n data=00001111
  Stimulus B: voltage bit val1=1 val0=0 delay=0 rise=10p fall=10p period=2.5n data=00110011
  Analysis tran: stop=20n
  Signals: /A, /B, /Cin, /Sum, /Cout
