ADE simulation setup
Run mode: Single Run, Sweeps and Corners
Tests:
  stdcell_rv32Lib_buf_1: stdcell_rv32Lib/buf/schematic, simulator spectre
