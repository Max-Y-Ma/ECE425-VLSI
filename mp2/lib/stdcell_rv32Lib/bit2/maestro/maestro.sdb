ADE simulation setup
Run mode: Single Run, Sweeps and Corners
Tests:
  stdcell_rv32Lib_bit2_1: stdcell_rv32Lib/bit2/schematic, simulator spectre
