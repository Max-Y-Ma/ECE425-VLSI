ADE simulation setup
Run mode: Single Run, Sweeps and Corners
Tests:
  stdcell_rv32Lib_mux2_1: stdcell_rv32Lib/mux2/schematic, simulator spectre
