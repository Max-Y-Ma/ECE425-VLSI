ADE simulation setup
Run mode: Single Run, Sweeps and Corners
Tests:
  stdcell_rv32Lib_inv_1: stdcell_rv32Lib/inv/schematic, simulator spectre
