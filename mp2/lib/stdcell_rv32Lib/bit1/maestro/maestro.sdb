ADE simulation setup
Run mode: Single Run, Sweeps and Corners
Tests:
  stdcell_rv32Lib_bit1_1: stdcell_rv32Lib/bit1/schematic, simulator spectre
