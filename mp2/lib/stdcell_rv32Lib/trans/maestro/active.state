ADE simulation setup
Test stdcell_rv32Lib_trans_1: stdcell_rv32Lib/trans/schematic, simulator spectre
  Models: /class/ece425/FreePDK45/ncsu_basekit/models/hspice/hspice_nom.include
  Temperature: 27
  Stimulus vdd!: voltage dc dc=1
  Stimulus vss!: voltage dc dc=0
  Stimulus A: voltage bit val1=1 val0=0 delay=0 rise=10p fall=10p period=2.5n data=0101
  Stimulus G: voltage bit val1=1 val0=0 delay=0 rise=10p fall=10p period=2.5n data=1100
  Stimulus Gb: voltage bit val1=1 val0=0 delay=0 rise=10p fall=10p period=2.5n data=0011
  Analysis tran: stop=10n
  Signals: /A, /Z
Run mode: Single Run, Sweeps and Corners
