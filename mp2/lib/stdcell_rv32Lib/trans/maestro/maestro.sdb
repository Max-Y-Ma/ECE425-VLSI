ADE simulation setup
Run mode: Single Run, Sweeps and Corners
Tests:
  stdcell_rv32Lib_trans_1: stdcell_rv32Lib/trans/schematic, simulator spectre
