ADE simulation setup
Run mode: Single Run, Sweeps and Corners
Tests:
  stdcell_rv32Lib_mux4_1: stdcell_rv32Lib/mux4/schematic, simulator spectre
