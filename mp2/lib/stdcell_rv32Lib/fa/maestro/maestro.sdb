ADE simulation setup
Run mode: Single Run, Sweeps and Corners
Tests:
  stdcell_rv32Lib_fa_1: stdcell_rv32Lib/fa/schematic, simulator spectre
