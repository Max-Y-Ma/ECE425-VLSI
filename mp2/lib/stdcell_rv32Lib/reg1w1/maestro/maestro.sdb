ADE simulation setup
Run mode: Single Run, Sweeps and Corners
Tests:
  stdcell_rv32Lib_reg1w1_1: stdcell_rv32Lib/reg1w1/schematic, simulator spectre
