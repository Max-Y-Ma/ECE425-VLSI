ADE simulation setup
Test stdcell_rv32Lib_mux6_1: stdcell_rv32Lib/mux6/schematic, simulator spectre
  Models: /class/ece425/FreePDK45/ncsu_basekit/models/hspice/hspice_nom.include
  Temperature: 27
  Stimulus vdd!: voltage dc dc=1
  Stimulus vss!: voltage dc dc=0
  Stimulus S0: voltage bit val1=1 val0=0 delay=0 rise=10p fall=10p period=2.5n data=010101
  Stimulus S1: voltage bit val1=1 val0=0 delay=0 rise=10p fall=10p period=2.5n data=001100
  Stimulus S2: voltage bit val1=1 val0=0 delay=0 rise=10p fall=10p period=2.5n data=000011
  Stimulus A: voltage bit val1=1 val0=0 delay=0 rise=10p fall=10p period=2.5n data=000000
  Stimulus B: voltage bit val1=1 val0=0 delay=0 rise=10p fall=10p period=2.5n data=111111
  Stimulus C: voltage bit val1=1 val0=0 delay=0 rise=10p fall=10p period=2.5n data=000000
  Stimulus D: voltage bit val1=1 val0=0 delay=0 rise=10p fall=10p period=2.5n data=111111
  Stimulus E: voltage bit val1=1 val0=0 delay=0 rise=10p fall=10p period=2.5n data=000000
  Stimulus F: voltage bit val1=1 val0=0 delay=0 rise=10p fall=10p period=2.5n data=111111
  Analysis tran: stop=15n
  Signals: /S0, /S1, /S2, /A, /B, /C, /D, /E, /F, /Z
