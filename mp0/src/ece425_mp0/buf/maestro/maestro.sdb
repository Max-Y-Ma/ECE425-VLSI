ADE simulation setup
Run mode: Single Run, Sweeps and Corners
Tests:
  ece425_mp0_buf_1: ece425_mp0/buf/schematic, simulator spectre
