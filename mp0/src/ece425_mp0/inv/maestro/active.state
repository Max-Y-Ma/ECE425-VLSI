ADE simulation setup
Test ece425_mp0_inv_1: ece425_mp0/inv/schematic, simulator spectre
  Models: /class/ece425/FreePDK45/ncsu_basekit/models/hspice/hspice_nom.include
  Temperature: 27
  Stimulus vss!: voltage dc dc=0
  Stimulus vdd!: voltage dc dc=1
  Stimulus A: voltage bit val1=1 val0=0 delay=0 rise=10p fall=10p period=2.5n data=0101
  Analysis tran: stop=10n
  Signals: /A, /Z
Run mode: Single Run, Sweeps and Corners
