ADE simulation setup
Run mode: Single Run, Sweeps and Corners
Tests:
  ece425_mp0_inv_1: ece425_mp0/inv/schematic, simulator spectre
