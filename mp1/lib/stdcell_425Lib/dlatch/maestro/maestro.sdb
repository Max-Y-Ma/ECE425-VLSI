ADE simulation setup
Run mode: Single Run, Sweeps and Corners
Tests:
  stdcell_425Lib_dlatch_1: stdcell_425Lib/dlatch/schematic, simulator spectre
