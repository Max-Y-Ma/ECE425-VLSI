ADE simulation setup
Test stdcell_425Lib_dlatch_1: stdcell_425Lib/dlatch/schematic, simulator spectre
  Models: /class/ece425/FreePDK45/ncsu_basekit/models/hspice/hspice_nom.include
  Temperature: 27
  Stimulus vss!: voltage dc dc=0
  Stimulus vdd!: voltage dc dc=1
  Stimulus D: voltage bit val1=1 val0=0 delay=0 rise=10p fall=10p period=2.5n data=01101001
  Stimulus EN: voltage bit val1=1 val0=0 delay=0 rise=10p fall=10p period=2.5n data=10101010
  Analysis tran: stop=20n
  Signals: /D, /EN, /Q, /Qb
Run mode: Single Run, Sweeps and Corners
