ADE simulation setup
Test stdcell_425Lib_dlatch_1: stdcell_425Lib/dlatch/schematic, simulator spectre
  Models: /class/ece425/FreePDK45/ncsu_basekit/models/hspice/hspice_nom.include
  Temperature: 27
  Stimulus D: voltage bit val1=1 val0=0 delay=0 rise=10p fall=10p period=2.5n data=01010101
  Stimulus EN: voltage bit val1=1 val0=0 delay=0 rise=10p fall=10p period=2.5n data=11110000
  Analysis tran: stop=20n
  Signals: /D, /net2, /Q, /EN, /ENB1, /EN1
Run mode: Single Run, Sweeps and Corners
