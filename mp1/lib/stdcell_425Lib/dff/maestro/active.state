ADE simulation setup
Test stdcell_425Lib_dff_1: stdcell_425Lib/dff/schematic, simulator spectre
  Models: /class/ece425/FreePDK45/ncsu_basekit/models/hspice/hspice_nom.include
  Temperature: 27
  Stimulus D: voltage bit val1=1 val0=0 delay=0 rise=10p fall=10p period=2.5n data=0110100111111111
  Stimulus CLK: voltage bit val1=1 val0=0 delay=0 rise=10p fall=10p period=2.5n data=0101010100001111
  Stimulus vdd!: voltage dc dc=1
  Stimulus vss!: voltage dc dc=0
  Analysis tran: stop=40n
  Signals: /D, /CLK, /Q, /Qb
Run mode: Single Run, Sweeps and Corners
