ADE simulation setup
Run mode: Single Run, Sweeps and Corners
Tests:
  stdcell_425Lib_dff_1: stdcell_425Lib/dff/schematic, simulator spectre
