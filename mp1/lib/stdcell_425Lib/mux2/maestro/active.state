ADE simulation setup
Test stdcell_425Lib_mux2_1: stdcell_425Lib/mux2/schematic, simulator spectre
  Models: /class/ece425/FreePDK45/ncsu_basekit/models/hspice/hspice_nom.include
  Temperature: 27
  Stimulus vdd!: voltage dc dc=1
  Stimulus vss!: voltage dc dc=0
  Stimulus S: voltage bit val1=1 val0=0 delay=0 rise=10p fall=10p period=2.5n data=01010101
  Stimulus A: voltage bit val1=1 val0=0 delay=0 rise=10p fall=10p period=2.5n data=00001111
  Stimulus B: voltage bit val1=1 val0=0 delay=0 rise=10p fall=10p period=2.5n data=00110011
  Analysis tran: stop=20n
  Signals: /B, /A, /S, /Z
Run mode: Single Run, Sweeps and Corners
