ADE simulation setup
Run mode: Single Run, Sweeps and Corners
Tests:
  stdcell_425Lib_xor2_1: stdcell_425Lib/xor2/schematic, simulator spectre
