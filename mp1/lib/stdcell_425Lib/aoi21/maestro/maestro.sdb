ADE simulation setup
Run mode: Single Run, Sweeps and Corners
Tests:
  stdcell_425Lib_aoi21_1: stdcell_425Lib/aoi21/schematic, simulator spectre
