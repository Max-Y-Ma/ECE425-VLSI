ADE simulation setup
Run mode: Single Run, Sweeps and Corners
Tests:
  stdcell_425Lib_buf_1: stdcell_425Lib/buf/schematic, simulator spectre
