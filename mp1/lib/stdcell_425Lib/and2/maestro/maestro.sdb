ADE simulation setup
Run mode: Single Run, Sweeps and Corners
Tests:
  stdcell_425Lib_and2_1: stdcell_425Lib/and2/schematic, simulator spectre
