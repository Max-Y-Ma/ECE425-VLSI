ADE simulation setup
Run mode: Single Run, Sweeps and Corners
Tests:
  stdcell_425Lib_oai21_1: stdcell_425Lib/oai21/schematic, simulator spectre
