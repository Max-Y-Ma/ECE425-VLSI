ADE simulation setup
Run mode: Single Run, Sweeps and Corners
Tests:
  stdcell_425Lib_transmission_1: stdcell_425Lib/transmission/schematic, simulator spectre
